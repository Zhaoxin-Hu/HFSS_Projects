# Ansys Electronics Desktop project, version 2017.1
project variables:
  $pad_g = 10um
  $pad_w = 0.05mm
  $pad_l = 0.5mm
  $pad_sep = 0.1mm
  $pad_l1 = 2mm
  $std_w1 = 0.4mm
  $std_w2 = 2mm
  $std_g = 0.027mm  # optimise 0.25mm..0.75mm
  $std_sep = 0.5*($std_w1+$std_w2)+$std_g
  $std_l1 = 0.5mm
  $std_l2 = 2.5mm
  $std_l3 = 10mm
  $std_l = 2mm
  $brd_t = 1um
  $brd_h = 0.1mm
  $brd_w = 10mm
  $port_w = 10*$std_w1
  $port_h = 11*($brd_h)
  $port_dep = 3*$brd_h
  $hole_d = 1mm
  $hole_s = 2mm
materials:
  vacuum: permittivity=1
  copper: permeability=0.999991 conductivity=58000000
  air: permittivity=1.0006 permeability=1.0000004
  Rogers RT/duroid 5880 (tm): permittivity=2.2 dielectric_loss_tangent=0.0009
  quartz_glass: permittivity=3.78

design CPWG (HFSS, DrivenModal, model units mm)
variables:
  ab_w = 1.5*$brd_w
  ab_h = $port_h+4*$brd_h
  ab_dep = $port_dep+2*$brd_h
geometry:
  sub [Rogers RT/duroid 5880 (tm)] = box(corner=(-$brd_w/2, 0mm, 0mm), size=($brd_w, 2*$std_l, -$brd_h))
  sig [copper] = box(corner=(-$std_w1/2, 0mm, 0mm), size=($std_w1, 2*$std_l, $brd_t))
  gnd_1 [copper] = box(corner=(-$std_w1/2-$std_g, 0mm, 0mm), size=(-$std_w2, 2*$std_l, $brd_t))
  gnd_2 [copper] = box(corner=($std_w1/2+$std_g, 0mm, 0mm), size=($std_w2, 2*$std_l, $brd_t))
  ab [air] = box(corner=(-ab_w/2, 0mm, -ab_dep), size=(ab_w, 2*$std_l, ab_h))
  port1 [air] = rectangle(corner=(-$port_w/2, 0mm, -$port_dep), z_size=$port_h, x_size=$port_w)
  port2 [air] = rectangle(corner=(-$port_w/2, 2*$std_l, -$port_dep), z_size=$port_h, x_size=$port_w)
  gnd [copper] = box(corner=(-$brd_w/2, 0, -$brd_h), size=($brd_w, 2*$std_l, -$brd_t))
  Cylinder1 [copper] = cylinder(axis=Z, base_centre=(-$std_w1/2-$std_g-$hole_s, $hole_s, 0), radius=$hole_d/2, height=-$brd_h)
  Cylinder2 [copper] = cylinder(axis=Z, base_centre=($std_w1/2+$std_g+$hole_s, $hole_s, 0), radius=$hole_d/2, height=-$brd_h)
  Cylinder3 [copper] = cylinder(axis=Z, base_centre=(-$std_w1/2-$std_g-$hole_s, 2*$hole_s, 0), radius=$hole_d/2, height=-$brd_h)
  Cylinder4 [copper] = cylinder(axis=Z, base_centre=($std_w1/2+$std_g+$hole_s, 2*$hole_s, 0), radius=$hole_d/2, height=-$brd_h)
  Cylinder5 [copper] = cylinder(axis=Z, base_centre=(-$std_w1/2-$std_g-$hole_s, 3*$hole_s, 0), radius=$hole_d/2, height=-$brd_h)
  Cylinder6 [copper] = cylinder(axis=Z, base_centre=($std_w1/2+$std_g+$hole_s, 3*$hole_s, 0), radius=$hole_d/2, height=-$brd_h)
  Cylinder7 [copper] = cylinder(axis=Z, base_centre=(-$std_w1/2-$std_g-$hole_s, 4*$hole_s, 0), radius=$hole_d/2, height=-$brd_h)
  Cylinder8 [copper] = cylinder(axis=Z, base_centre=($std_w1/2+$std_g+$hole_s, 4*$hole_s, 0), radius=$hole_d/2, height=-$brd_h)
  Cylinder9 = cylinder(axis=Z, base_centre=(-$std_w1/2-$std_g-$hole_s, $hole_s, 0), radius=$hole_d/2, height=-$brd_h)
  Cylinder10 = cylinder(axis=Z, base_centre=($std_w1/2+$std_g+$hole_s, $hole_s, 0), radius=$hole_d/2, height=-$brd_h)
  Cylinder11 = cylinder(axis=Z, base_centre=(-$std_w1/2-$std_g-$hole_s, 2*$hole_s, 0), radius=$hole_d/2, height=-$brd_h)
  Cylinder12 = cylinder(axis=Z, base_centre=($std_w1/2+$std_g+$hole_s, 2*$hole_s, 0), radius=$hole_d/2, height=-$brd_h)
  Cylinder13 = cylinder(axis=Z, base_centre=(-$std_w1/2-$std_g-$hole_s, 3*$hole_s, 0), radius=$hole_d/2, height=-$brd_h)
  Cylinder14 = cylinder(axis=Z, base_centre=($std_w1/2+$std_g+$hole_s, 3*$hole_s, 0), radius=$hole_d/2, height=-$brd_h)
  Cylinder15 = cylinder(axis=Z, base_centre=(-$std_w1/2-$std_g-$hole_s, 4*$hole_s, 0), radius=$hole_d/2, height=-$brd_h)
  Cylinder16 = cylinder(axis=Z, base_centre=($std_w1/2+$std_g+$hole_s, 4*$hole_s, 0), radius=$hole_d/2, height=-$brd_h)
  sub.subtract(Cylinder10..Cylinder16, Cylinder9)
boundaries and excitations:
  Rad1: Radiation Objects=ab
  1: Wave Port Objects=port1 NumModes=3 Modes{Mode1{IntLine{sig.vertex(4 of 8) -> gnd_1.vertex(1 of 8)} CharImp=Zpi} Mode2{CharImp=Zpi} Mode3{CharImp=Zpi}}
  2: Wave Port Objects=port2 NumModes=3 Modes{Mode1{IntLine{sig.vertex(3 of 8) -> gnd_1.vertex(2 of 8)} CharImp=Zpi} Mode2{CharImp=Zpi} Mode3{CharImp=Zpi}}
setups:
  Setup1: HfssDriven Frequency=50GHz MaxDeltaS=0.02 MaximumPasses=10 MinimumPasses=1 MinimumConvergedPasses=1 PercentRefinement=30 BasisOrder=1 PortAccuracy=2 RayDensityPerWavelength=4 MaxNumberOfBounces=5
    sweep Sweep: 45GHz to 55GHz, 101 points; disabled Type=Interpolating InterpTolerance=0.5 InterpMaxSolns=250 InterpUsePortImped=false PassivityErrorTolerance=0.0001
source amplitudes:
  1:1: 1W 0deg
  1:2, 1:3, 2:1, 2:2, 2:3: 0W 0deg
optimetrics:
  OptimizationSetup1: Optimization Optimizer="Quasi Newton" AnalysisStopOptions{StopForNumIteration MaxNumIteration=1000 MinNumIteration=10} CostFuncNormType=L2 Acceptable_Cost=0 Noise=0.0001 UpdateDesignWhenDone
    vary $std_g: Min=0.15mm Max=0.5mm MinStep=0.05mm MaxStep=0.2mm MinFocus=0.25mm MaxFocus=0.75mm start=0.168mm
    goal re(Zo(1:1)) == 100 weight 1 on Setup1 : LastAdaptive at Freq 50GHz
  ParametricSetup1: Parametric Sim._Setups=[Setup1]
    sweep $hole_s: LIN 2mm 4mm 1mm
field plots:
  Mesh1: MeshPlots over port1.face on Setup1 : LastAdaptive at Freq=50GHz Phase=0deg
  Mag_E1, Vector_E1: E Field over port1.face on Setup1 : LastAdaptive at Freq=50GHz Phase=0deg
  Mag_E2: E Field in ab on Setup1 : LastAdaptive at Freq=50GHz Phase=0deg

design CPW Pad and THRU Quartz (HFSS, DrivenModal, model units mm)
variables:
  ab_w = 1.5*$brd_w
  ab_h = $port_h+4*$brd_h
  ab_dep = $port_dep+2*$brd_h
geometry:
  sub [quartz_glass] = box(corner=(-$brd_w/2, 0mm, 0mm), size=($brd_w, 2*($std_l+$pad_l+$pad_l1), -$brd_h))
  pad = box(corner=(-$pad_w/2, 0mm, 0mm), size=($pad_w, $pad_l, $brd_t))
  gnd_1 [copper] = box(corner=(-$pad_w/2-$pad_g, 0mm, 0mm), size=(-$std_w2, $pad_l, $brd_t))
  gnd_2 [copper] = box(corner=($pad_w/2+$pad_g, 0mm, 0mm), size=($std_w2, $pad_l, $brd_t))
  ab [air] = box(corner=(-ab_w/2, 0mm, -ab_dep), size=(ab_w, 2*($std_l+$pad_l+$pad_l1), ab_h))
  port1 [air] = rectangle(corner=(-$port_w/2, 0mm, -$port_dep), z_size=$port_h, x_size=$port_w)
  port2 [air] = rectangle(corner=(-$port_w/2, 2*($std_l+$pad_l+$pad_l1), -$port_dep), z_size=$port_h, x_size=$port_w)
  gnd_3 = box(corner=(-$std_w1/2-$std_g, $pad_l+$pad_l1, 0mm), size=(-$std_w2, 2*$std_l, $brd_t))
  gnd_4 = box(corner=($std_w1/2+$std_g, $pad_l+$pad_l1, 0mm), size=($std_w2, 2*$std_l, $brd_t))
  sig [copper] = box(corner=(-$std_w1/2, $pad_l+$pad_l1, 0mm), size=($std_w1, 2*$std_l, $brd_t))
  gnd_5 = box(corner=(-$pad_w/2-$pad_g, 2*($std_l+$pad_l+$pad_l1), 0mm), size=(-$std_w2, -$pad_l, $brd_t))
  gnd_6 = box(corner=($pad_w/2+$pad_g, 2*($std_l+$pad_l+$pad_l1), 0mm), size=($std_w2, -$pad_l, $brd_t))
  pad1 = box(corner=(-$pad_w/2, 2*($std_l+$pad_l+$pad_l1), 0mm), size=($pad_w, -$pad_l, $brd_t))
  Polyline1 = polyline(z=0mm, xy: (-$pad_w/2-$pad_g, $pad_l) (-$std_w1/2-$std_g, $pad_l+$pad_l1) (-$std_w1/2-$std_g-$std_w2, $pad_l+$pad_l1) (-$pad_w/2-$pad_g-$std_w2, $pad_l) (-$pad_w/2-$pad_g, $pad_l), closed, covered)
  Polyline2 = polyline(z=0mm, xy: ($pad_w/2+$pad_g, $pad_l) ($std_w1/2+$std_g, $pad_l+$pad_l1) ($std_w1/2+$std_g+$std_w2, $pad_l+$pad_l1) ($pad_w/2+$pad_g+$std_w2, $pad_l) ($pad_w/2+$pad_g, $pad_l), closed, covered)
  Polyline3 = polyline(z=0mm, xy: (-$std_w1/2-$std_g, $pad_l+2*($std_l)+$pad_l1) (-$pad_w/2-$pad_g, 2*($pad_l1+$std_l)+$pad_l) (-$pad_w/2-$pad_g-$std_w2, 2*($pad_l1+$std_l)+$pad_l) (-$std_w1/2-$std_g-$std_w2, $pad_l+2*($std_l)+$pad_l1) (-$std_w1/2-$std_g, $pad_l+2*($std_l)+$pad_l1), closed, covered)
  Polyline4 = polyline(z=0mm, xy: ($std_w1/2+$std_g, $pad_l+2*($std_l)+$pad_l1) ($pad_w/2+$pad_g, 2*($pad_l1+$std_l)+$pad_l) ($pad_w/2+$pad_g+$std_w2, 2*($pad_l1+$std_l)+$pad_l) ($std_w1/2+$std_g+$std_w2, $pad_l+2*($std_l)+$pad_l1) ($std_w1/2+$std_g, $pad_l+2*($std_l)+$pad_l1), closed, covered)
  Polyline1_SweepFaceAlongNormal1 = sweep_along_normal(Polyline1.face(#350), length=$brd_t)
  Polyline1.delete()
  Polyline2_SweepFaceAlongNormal1 = sweep_along_normal(Polyline2.face(#362), length=-$brd_t)
  Polyline2.delete()
  Polyline3_SweepFaceAlongNormal1 = sweep_along_normal(Polyline3.face(#374), length=$brd_t)
  Polyline3.delete()
  Polyline4_SweepFaceAlongNormal1 = sweep_along_normal(Polyline4.face(#386), length=-$brd_t)
  Polyline4.delete()
  Polyline5 = polyline(z=0mm, xy: (-$pad_w/2, $pad_l) (-$std_w1/2, $pad_l+$pad_l1) ($std_w1/2, $pad_l+$pad_l1) ($pad_w/2, $pad_l) (-$pad_w/2, $pad_l), closed, covered)
  Polyline6 = polyline(z=0mm, xy: ($std_w1/2, 2*$std_l+$pad_l+$pad_l1) ($pad_w/2, 2*$std_l+$pad_l+2*$pad_l1) (-$pad_w/2, 2*$std_l+$pad_l+2*$pad_l1) (-$std_w1/2, 2*$std_l+$pad_l+$pad_l1) ($std_w1/2, 2*$std_l+$pad_l+$pad_l1), closed, covered)
  Polyline5.thicken(-$brd_t)
  Polyline6_SweepFaceAlongNormal1 = sweep_along_normal(Polyline6.face(#528), length=$brd_t)
  Polyline6.delete()
  gnd_1.unite(Polyline1_SweepFaceAlongNormal1, gnd_3, Polyline3_SweepFaceAlongNormal1, gnd_5)
  gnd_2.unite(gnd_4, gnd_6, Polyline2_SweepFaceAlongNormal1, Polyline4_SweepFaceAlongNormal1)
  sig.unite(pad, pad1, Polyline5, Polyline6_SweepFaceAlongNormal1)
boundaries and excitations:
  Rad1: Radiation Objects=ab
  1: Wave Port Objects=port1 NumModes=3 Modes{Mode1{CharImp=Zpi} Mode2{CharImp=Zpi} Mode3{CharImp=Zpi}}
  2: Wave Port Objects=port2 NumModes=3 Modes{Mode1{CharImp=Zpi} Mode2{CharImp=Zpi} Mode3{CharImp=Zpi}}
setups:
  Setup1: HfssDriven Frequency=90GHz MaxDeltaS=0.02 MaximumPasses=15 MinimumPasses=1 MinimumConvergedPasses=1 PercentRefinement=30 BasisOrder=1 PortAccuracy=2 RayDensityPerWavelength=4 MaxNumberOfBounces=5
    sweep Sweep: 85GHz to 95GHz, 51 points; Type=Interpolating InterpTolerance=0.5 InterpMaxSolns=250 InterpUsePortImped=false PassivityErrorTolerance=0.0001
source amplitudes:
  1:1: 1W 0deg
  1:2, 1:3, 2:1, 2:2, 2:3: 0W 0deg
optimetrics:
  OptimizationSetup1: Optimization Optimizer="Quasi Newton" AnalysisStopOptions{StopForNumIteration MaxNumIteration=1000 MinNumIteration=10} CostFuncNormType=L2 Acceptable_Cost=0 Noise=0.0001 UpdateDesignWhenDone
    vary $std_g: Min=0.15mm Max=0.5mm MinStep=0.05mm MaxStep=0.2mm MinFocus=0.25mm MaxFocus=0.75mm start=0.168mm
    goal re(Zo(1:1)) == 100 weight 1 on Setup1 : LastAdaptive at Freq 50GHz
  ParametricSetup1: Parametric Sim._Setups=[Setup1]
    sweep $std_g: LIN 0.15mm 0.2mm 0.01mm
field plots:
  Mesh1: MeshPlots over port1.face on Setup1 : LastAdaptive at Freq=90GHz Phase=0deg
  Mag_E1: E Field over port1.face on Setup1 : LastAdaptive at Freq=90GHz Phase=0deg
reports:
  Port Zo Plot 1: re(Zo(1:1)) vs $std_g on Setup1 : LastAdaptive [Freq=all]
  S Parameter Plot 1: dB(S(1:1,1:1)) vs Freq on Setup1 : Sweep [$std_g=all]
  Lambda Plot 1: Lambda(1:1) vs Freq on Setup1 : Sweep [$pad_g=27um $std_g=all]; markers m1 at 90GHz
  Epsilon Plot 1: Epsilon(1:1) vs Freq on Setup1 : Sweep [$pad_g=27um $std_g=all]; markers m1 at 90GHz

design CPW Quartz (50 Ohm) (HFSS, DrivenModal, model units mm)
variables:
  ab_w = 1.5*$brd_w
  ab_h = $port_h+4*$brd_h
  ab_dep = $port_dep+2*$brd_h
geometry:
  sub [quartz_glass] = box(corner=(-$brd_w/2, 0mm, 0mm), size=($brd_w, 2*$std_l, -$brd_h))
  sig [copper] = box(corner=(-$std_w1/2, 0mm, 0mm), size=($std_w1, 2*$std_l, $brd_t))
  gnd_1 [copper] = box(corner=(-$std_w1/2-$std_g, 0mm, 0mm), size=(-$std_w2, 2*$std_l, $brd_t))
  gnd_2 [copper] = box(corner=($std_w1/2+$std_g, 0mm, 0mm), size=($std_w2, 2*$std_l, $brd_t))
  ab [air] = box(corner=(-ab_w/2, 0mm, -ab_dep), size=(ab_w, 2*$std_l, ab_h))
  port1 [air] = rectangle(corner=(-$port_w/2, 0mm, -$port_dep), z_size=$port_h, x_size=$port_w)
  port2 [air] = rectangle(corner=(-$port_w/2, 2*$std_l, -$port_dep), z_size=$port_h, x_size=$port_w)
boundaries and excitations:
  Rad1: Radiation Objects=ab
  1: Wave Port Objects=port1 NumModes=3 Modes{Mode1{IntLine{sig.vertex(4 of 8) -> gnd_1.vertex(1 of 8)} CharImp=Zpi} Mode2{CharImp=Zpi} Mode3{CharImp=Zpi}}
  2: Wave Port Objects=port2 NumModes=3 Modes{Mode1{IntLine{sig.vertex(3 of 8) -> gnd_1.vertex(2 of 8)} CharImp=Zpi} Mode2{CharImp=Zpi} Mode3{CharImp=Zpi}}
setups:
  Setup1: HfssDriven Frequency=5GHz MaxDeltaS=0.02 MaximumPasses=15 MinimumPasses=1 MinimumConvergedPasses=1 PercentRefinement=30 BasisOrder=1 PortAccuracy=2 RayDensityPerWavelength=4 MaxNumberOfBounces=5
    sweep Sweep: 1GHz to 10GHz, 91 points; Type=Interpolating InterpTolerance=0.5 InterpMaxSolns=250 InterpUsePortImped=false PassivityErrorTolerance=0.0001
  Setup2: HfssDriven Frequency=50GHz MaxDeltaS=0.02 MaximumPasses=15 MinimumPasses=1 MinimumConvergedPasses=1 PercentRefinement=30 BasisOrder=1 PortAccuracy=2 RayDensityPerWavelength=4 MaxNumberOfBounces=5
    sweep Sweep: 45GHz to 55GHz, 51 points; Type=Interpolating InterpTolerance=0.5 InterpMaxSolns=250 InterpUsePortImped=false PassivityErrorTolerance=0.0001
  Setup3: HfssDriven Frequency=90GHz MaxDeltaS=0.02 MaximumPasses=15 MinimumPasses=1 MinimumConvergedPasses=1 PercentRefinement=30 BasisOrder=1 PortAccuracy=2 RayDensityPerWavelength=4 MaxNumberOfBounces=5
    sweep Sweep: 85GHz to 95GHz, 51 points; Type=Interpolating InterpTolerance=0.5 InterpMaxSolns=250 InterpUsePortImped=false PassivityErrorTolerance=0.0001
source amplitudes:
  1:1: 1W 0deg
  1:2, 1:3, 2:1, 2:2, 2:3: 0W 0deg
optimetrics:
  OptimizationSetup1: Optimization Optimizer="Quasi Newton" AnalysisStopOptions{StopForNumIteration MaxNumIteration=1000 MinNumIteration=10} CostFuncNormType=L2 Acceptable_Cost=0 Noise=0.0001 UpdateDesignWhenDone
    vary $std_g: Min=0.15mm Max=0.5mm MinStep=0.05mm MaxStep=0.2mm MinFocus=0.25mm MaxFocus=0.75mm start=0.168mm
    goal re(Zo(1:1)) == 100 weight 1 on ? at Freq 50GHz
  ParametricSetup1: Parametric
    sweep $brd_t: LIN 1um 10um 3um
reports:
  S Parameter Plot 1: dB(S(1:1,1:1)) vs Freq on Setup1 : Sweep [$pad_g=10um $brd_t=all]; dB(S(1:1,1:1)) vs Freq on Setup2 : Sweep [$pad_g=10um $brd_t=all]; dB(S(1:1,1:1)) vs Freq on Setup3 : Sweep [$pad_g=10um $brd_t=all]
  Epsilon Plot 1: Epsilon(1:1) vs Freq on Setup1 : Sweep [$pad_g=10um $brd_t=all]; Epsilon(1:1) vs Freq on Setup2 : Sweep [$pad_g=10um $brd_t=all]; Epsilon(1:1) vs Freq on Setup3 : Sweep [$pad_g=10um $brd_t=all]; markers m1 at 5GHz, m2 at 50GHz, m3 at 90GHz
  Lambda Plot 1: Lambda(1:1) vs Freq on Setup1 : Sweep [$pad_g=10um $brd_t=all]; Lambda(1:1) vs Freq on Setup2 : Sweep [$pad_g=10um $brd_t=all]; Lambda(1:1) vs Freq on Setup3 : Sweep [$pad_g=10um $brd_t=all]; markers m1 at 5GHz, m2 at 50GHz, m3 at 90GHz

design CPWG Pad (HFSS, DrivenModal, model units mm)
variables:
  ab_w = 1.5*$brd_w
  ab_h = $port_h+4*$brd_h
  ab_dep = $port_dep+2*$brd_h
geometry:
  sub [Rogers RT/duroid 5880 (tm)] = box(corner=(-$brd_w/2, 0mm, 0mm), size=($brd_w, 2*$std_l, -$brd_h))
  sig [copper] = box(corner=(-$pad_w/2, 0mm, 0mm), size=($pad_w, 2*$std_l, $brd_t))
  gnd_1 [copper] = box(corner=(-$pad_w/2-$pad_g, 0mm, 0mm), size=(-$std_w2, 2*$std_l, $brd_t))
  gnd_2 [copper] = box(corner=($pad_w/2+$pad_g, 0mm, 0mm), size=($std_w2, 2*$std_l, $brd_t))
  ab [air] = box(corner=(-ab_w/2, 0mm, -ab_dep), size=(ab_w, 2*$std_l, ab_h))
  port1 [air] = rectangle(corner=(-$port_w/2, 0mm, -$port_dep), z_size=$port_h, x_size=$port_w)
  port2 [air] = rectangle(corner=(-$port_w/2, 2*$std_l, -$port_dep), z_size=$port_h, x_size=$port_w)
  Cylinder1 [copper] = cylinder(axis=Z, base_centre=(-$pad_w/2-$pad_g-$hole_s, $hole_s, 0), radius=$hole_d/2, height=-$brd_h)
  Cylinder2 [copper] = cylinder(axis=Z, base_centre=($pad_w/2+$pad_g+$hole_s, $hole_s, 0), radius=$hole_d/2, height=-$brd_h)
  Cylinder3 [copper] = cylinder(axis=Z, base_centre=(-$pad_w/2-$pad_g-$hole_s, 2*$hole_s, 0), radius=$hole_d/2, height=-$brd_h)
  Cylinder4 [copper] = cylinder(axis=Z, base_centre=($pad_w/2+$pad_g+$hole_s, 2*$hole_s, 0), radius=$hole_d/2, height=-$brd_h)
  Cylinder5 [copper] = cylinder(axis=Z, base_centre=(-$pad_w/2-$pad_g-$hole_s, 3*$hole_s, 0), radius=$hole_d/2, height=-$brd_h)
  Cylinder6 [copper] = cylinder(axis=Z, base_centre=($pad_w/2+$pad_g+$hole_s, 3*$hole_s, 0), radius=$hole_d/2, height=-$brd_h)
  Cylinder7 [copper] = cylinder(axis=Z, base_centre=(-$pad_w/2-$pad_g-$hole_s, 4*$hole_s, 0), radius=$hole_d/2, height=-$brd_h)
  Cylinder8 [copper] = cylinder(axis=Z, base_centre=($pad_w/2+$pad_g+$hole_s, 4*$hole_s, 0), radius=$hole_d/2, height=-$brd_h)
  Cylinder9 = cylinder(axis=Z, base_centre=(-$pad_w/2-$pad_g-$hole_s, $hole_s, 0), radius=$hole_d/2, height=-$brd_h)
  Cylinder10 = cylinder(axis=Z, base_centre=($pad_w/2+$pad_g+$hole_s, $hole_s, 0), radius=$hole_d/2, height=-$brd_h)
  Cylinder11 = cylinder(axis=Z, base_centre=(-$pad_w/2-$pad_g-$hole_s, 2*$hole_s, 0), radius=$hole_d/2, height=-$brd_h)
  Cylinder12 = cylinder(axis=Z, base_centre=($pad_w/2+$pad_g+$hole_s, 2*$hole_s, 0), radius=$hole_d/2, height=-$brd_h)
  Cylinder13 = cylinder(axis=Z, base_centre=(-$pad_w/2-$pad_g-$hole_s, 3*$hole_s, 0), radius=$hole_d/2, height=-$brd_h)
  Cylinder14 = cylinder(axis=Z, base_centre=($pad_w/2+$pad_g+$hole_s, 3*$hole_s, 0), radius=$hole_d/2, height=-$brd_h)
  Cylinder15 = cylinder(axis=Z, base_centre=(-$pad_w/2-$pad_g-$hole_s, 4*$hole_s, 0), radius=$hole_d/2, height=-$brd_h)
  Cylinder16 = cylinder(axis=Z, base_centre=($pad_w/2+$pad_g+$hole_s, 4*$hole_s, 0), radius=$hole_d/2, height=-$brd_h)
  sub.subtract(Cylinder10..Cylinder16, Cylinder9)
  gnd [copper] = box(corner=(-$brd_w/2, 0, -$brd_h), size=($brd_w, 2*$std_l, -$brd_t))
boundaries and excitations:
  Rad1: Radiation Objects=ab
  1: Wave Port Objects=port1 NumModes=3 Modes{Mode1{IntLine{sig.vertex(4 of 8) -> gnd_1.vertex(1 of 8)} CharImp=Zpi} Mode2{CharImp=Zpi} Mode3{CharImp=Zpi}}
  2: Wave Port Objects=port2 NumModes=3 Modes{Mode1{IntLine{sig.vertex(3 of 8) -> gnd_1.vertex(2 of 8)} CharImp=Zpi} Mode2{CharImp=Zpi} Mode3{CharImp=Zpi}}
setups:
  Setup1: HfssDriven Frequency=50GHz MaxDeltaS=0.02 MaximumPasses=10 MinimumPasses=1 MinimumConvergedPasses=1 PercentRefinement=30 BasisOrder=1 PortAccuracy=2 RayDensityPerWavelength=4 MaxNumberOfBounces=5
    sweep Sweep: 45GHz to 55GHz, 101 points; disabled Type=Interpolating InterpTolerance=0.5 InterpMaxSolns=250 InterpUsePortImped=false PassivityErrorTolerance=0.0001
source amplitudes:
  1:1: 1W 0deg
  1:2, 1:3, 2:1, 2:2, 2:3: 0W 0deg
optimetrics:
  OptimizationSetup1: Optimization Optimizer="Quasi Newton" AnalysisStopOptions{StopForNumIteration MaxNumIteration=1000 MinNumIteration=10} CostFuncNormType=L2 Acceptable_Cost=0 Noise=0.0001 UpdateDesignWhenDone
    vary $std_g: Min=0.15mm Max=0.5mm MinStep=0.05mm MaxStep=0.2mm MinFocus=0.25mm MaxFocus=0.75mm start=0.168mm
    goal re(Zo(1:1)) == 100 weight 1 on Setup1 : LastAdaptive at Freq 50GHz
  ParametricSetup1: Parametric Sim._Setups=[Setup1]
    sweep $pad_g: LIN 0.01mm 0.05mm 0.01mm
field plots:
  Mesh1: MeshPlots over port1.face on Setup1 : LastAdaptive at Freq=50GHz Phase=0deg
  Mag_E1: E Field over port1.face on Setup1 : LastAdaptive at Freq=50GHz Phase=0deg
reports:
  Port Zo Plot 1: re(Zo(1:1)) vs $pad_g on Setup1 : LastAdaptive [Freq=all]; markers m1 at 13.652968um

design CPW Pad Quartz (HFSS, DrivenModal, model units mm)
variables:
  ab_w = 1.5*$brd_w
  ab_h = $port_h+4*$brd_h
  ab_dep = $port_dep+2*$brd_h
geometry:
  sub [quartz_glass] = box(corner=(-$brd_w/2, 0mm, 0mm), size=($brd_w, 2*$std_l, -$brd_h))
  sig [copper] = box(corner=(-$pad_w/2, 0mm, 0mm), size=($pad_w, 2*$std_l, $brd_t))
  gnd_1 [copper] = box(corner=(-$pad_w/2-$pad_g, 0mm, 0mm), size=(-$std_w2, 2*$std_l, $brd_t))
  gnd_2 [copper] = box(corner=($pad_w/2+$pad_g, 0mm, 0mm), size=($std_w2, 2*$std_l, $brd_t))
  ab [air] = box(corner=(-ab_w/2, 0mm, -ab_dep), size=(ab_w, 2*$std_l, ab_h))
  port1 [air] = rectangle(corner=(-$port_w/2, 0mm, -$port_dep), z_size=$port_h, x_size=$port_w)
  port2 [air] = rectangle(corner=(-$port_w/2, 2*$std_l, -$port_dep), z_size=$port_h, x_size=$port_w)
boundaries and excitations:
  Rad1: Radiation Objects=ab
  1: Wave Port Objects=port1 NumModes=3 Modes{Mode1{IntLine{sig.vertex(4 of 8) -> gnd_1.vertex(1 of 8)} CharImp=Zpi} Mode2{CharImp=Zpi} Mode3{CharImp=Zpi}}
  2: Wave Port Objects=port2 NumModes=3 Modes{Mode1{IntLine{sig.vertex(3 of 8) -> gnd_1.vertex(2 of 8)} CharImp=Zpi} Mode2{CharImp=Zpi} Mode3{CharImp=Zpi}}
setups:
  Setup3: HfssDriven Frequency=90GHz MaxDeltaS=0.02 MaximumPasses=15 MinimumPasses=1 MinimumConvergedPasses=1 PercentRefinement=30 BasisOrder=1 PortAccuracy=2 RayDensityPerWavelength=4 MaxNumberOfBounces=5
    sweep Sweep: 85GHz to 95GHz, 51 points; Type=Interpolating InterpTolerance=0.5 InterpMaxSolns=250 InterpUsePortImped=false PassivityErrorTolerance=0.0001
  Setup2: HfssDriven Frequency=50GHz MaxDeltaS=0.02 MaximumPasses=15 MinimumPasses=1 MinimumConvergedPasses=1 PercentRefinement=30 BasisOrder=1 PortAccuracy=2 RayDensityPerWavelength=4 MaxNumberOfBounces=5
    sweep Sweep: 45GHz to 55GHz, 51 points; Type=Interpolating InterpTolerance=0.5 InterpMaxSolns=250 InterpUsePortImped=false PassivityErrorTolerance=0.0001
  Setup1: HfssDriven Frequency=5GHz MaxDeltaS=0.02 MaximumPasses=15 MinimumPasses=1 MinimumConvergedPasses=1 PercentRefinement=30 BasisOrder=1 PortAccuracy=2 RayDensityPerWavelength=4 MaxNumberOfBounces=5
    sweep Sweep: 1GHz to 10GHz, 91 points; Type=Interpolating InterpTolerance=0.5 InterpMaxSolns=250 InterpUsePortImped=false PassivityErrorTolerance=0.0001
source amplitudes:
  1:1: 1W 0deg
  1:2, 1:3, 2:1, 2:2, 2:3: 0W 0deg
optimetrics:
  OptimizationSetup1: Optimization Optimizer="Quasi Newton" AnalysisStopOptions{StopForNumIteration MaxNumIteration=1000 MinNumIteration=10} CostFuncNormType=L2 Acceptable_Cost=0 Noise=0.0001 UpdateDesignWhenDone
    vary $std_g: Min=0.15mm Max=0.5mm MinStep=0.05mm MaxStep=0.2mm MinFocus=0.25mm MaxFocus=0.75mm start=0.168mm
    goal re(Zo(1:1)) == 100 weight 1 on ? at Freq 50GHz
  ParametricSetup1: Parametric
    sweep $pad_g: LIN 0.01mm 0.05mm 0.01mm
reports:
  S Parameter Plot 1: dB(S(1:1,1:1)) vs Freq on Setup1 : Sweep [$pad_g=10um]; dB(S(1:1,1:1)) vs Freq on Setup2 : Sweep [$pad_g=10um]; dB(S(1:1,1:1)) vs Freq on Setup3 : Sweep [$pad_g=10um]
  Epsilon Plot 1: Epsilon(1:1) vs Freq on Setup1 : Sweep [$pad_g=10um]; Epsilon(1:1) vs Freq on Setup2 : Sweep [$pad_g=10um]; Epsilon(1:1) vs Freq on Setup3 : Sweep [$pad_g=10um]; markers m1 at 5GHz, m2 at 50GHz, m3 at 90GHz
  Lambda Plot 1: Lambda(1:1) vs Freq on Setup1 : Sweep [$pad_g=10um]; Lambda(1:1) vs Freq on Setup2 : Sweep [$pad_g=10um]; Lambda(1:1) vs Freq on Setup3 : Sweep [$pad_g=10um]; markers m1 at 5GHz, m2 at 50GHz, m3 at 90GHz

design CPW Pad and LINE Quartz (HFSS, DrivenModal, model units mm)
variables:
  ab_w = 1.5*$brd_w
  ab_h = $port_h+4*$brd_h
  ab_dep = $port_dep+2*$brd_h
  l = $std_l1
geometry:
  sub [quartz_glass] = box(corner=(-$brd_w/2, 0mm, 0mm), size=($brd_w, 2*($std_l+$pad_l+$pad_l1)+l, -$brd_h))
  pad = box(corner=(-$pad_w/2, 0mm, 0mm), size=($pad_w, $pad_l, $brd_t))
  gnd_1 [copper] = box(corner=(-$pad_w/2-$pad_g, 0mm, 0mm), size=(-$std_w2, $pad_l, $brd_t))
  gnd_2 [copper] = box(corner=($pad_w/2+$pad_g, 0mm, 0mm), size=($std_w2, $pad_l, $brd_t))
  ab [air] = box(corner=(-ab_w/2, 0mm, -ab_dep), size=(ab_w, 2*($std_l+$pad_l+$pad_l1)+l, ab_h))
  port1 [air] = rectangle(corner=(-$port_w/2, 0mm, -$port_dep), z_size=$port_h, x_size=$port_w)
  port2 [air] = rectangle(corner=(-$port_w/2, 2*($std_l+$pad_l+$pad_l1)+l, -$port_dep), z_size=$port_h, x_size=$port_w)
  gnd_3 = box(corner=(-$std_w1/2-$std_g, $pad_l+$pad_l1, 0mm), size=(-$std_w2, 2*$std_l+l, $brd_t))
  gnd_4 = box(corner=($std_w1/2+$std_g, $pad_l+$pad_l1, 0mm), size=($std_w2, 2*$std_l+l, $brd_t))
  sig [copper] = box(corner=(-$std_w1/2, $pad_l+$pad_l1, 0mm), size=($std_w1, 2*$std_l+l, $brd_t))
  gnd_5 = box(corner=(-$pad_w/2-$pad_g, 2*($std_l+$pad_l+$pad_l1)+l, 0mm), size=(-$std_w2, -$pad_l, $brd_t))
  gnd_6 = box(corner=($pad_w/2+$pad_g, 2*($std_l+$pad_l+$pad_l1)+l, 0mm), size=($std_w2, -$pad_l, $brd_t))
  pad1 = box(corner=(-$pad_w/2, 2*($std_l+$pad_l+$pad_l1)+l, 0mm), size=($pad_w, -$pad_l, $brd_t))
  Polyline1 = polyline(z=0mm, xy: (-$pad_w/2-$pad_g, $pad_l) (-$std_w1/2-$std_g, $pad_l+$pad_l1) (-$std_w1/2-$std_g-$std_w2, $pad_l+$pad_l1) (-$pad_w/2-$pad_g-$std_w2, $pad_l) (-$pad_w/2-$pad_g, $pad_l), closed, covered)
  Polyline2 = polyline(z=0mm, xy: ($pad_w/2+$pad_g, $pad_l) ($std_w1/2+$std_g, $pad_l+$pad_l1) ($std_w1/2+$std_g+$std_w2, $pad_l+$pad_l1) ($pad_w/2+$pad_g+$std_w2, $pad_l) ($pad_w/2+$pad_g, $pad_l), closed, covered)
  Polyline3 = polyline(z=0mm, xy: (-$std_w1/2-$std_g, $pad_l+2*($std_l)+$pad_l1+l) (-$pad_w/2-$pad_g, 2*($pad_l1+$std_l)+$pad_l+l) (-$pad_w/2-$pad_g-$std_w2, 2*($pad_l1+$std_l)+$pad_l+l) (-$std_w1/2-$std_g-$std_w2, $pad_l+2*($std_l)+$pad_l1+l) (-$std_w1/2-$std_g, $pad_l+2*($std_l)+$pad_l1+l), closed, covered)
  Polyline4 = polyline(z=0mm, xy: ($std_w1/2+$std_g, $pad_l+2*($std_l)+$pad_l1+l) ($pad_w/2+$pad_g, 2*($pad_l1+$std_l)+$pad_l+l) ($pad_w/2+$pad_g+$std_w2, 2*($pad_l1+$std_l)+$pad_l+l) ($std_w1/2+$std_g+$std_w2, $pad_l+2*($std_l)+$pad_l1+l) ($std_w1/2+$std_g, $pad_l+2*($std_l)+$pad_l1+l), closed, covered)
  Polyline1_SweepFaceAlongNormal1 = sweep_along_normal(Polyline1.face(#350), length=$brd_t)
  Polyline1.delete()
  Polyline2_SweepFaceAlongNormal1 = sweep_along_normal(Polyline2.face(#362), length=-$brd_t)
  Polyline2.delete()
  Polyline3_SweepFaceAlongNormal1 = sweep_along_normal(Polyline3.face(#374), length=$brd_t)
  Polyline3.delete()
  Polyline4_SweepFaceAlongNormal1 = sweep_along_normal(Polyline4.face(#386), length=-$brd_t)
  Polyline4.delete()
  Polyline5 = polyline(z=0mm, xy: (-$pad_w/2, $pad_l) (-$std_w1/2, $pad_l+$pad_l1) ($std_w1/2, $pad_l+$pad_l1) ($pad_w/2, $pad_l) (-$pad_w/2, $pad_l), closed, covered)
  Polyline6 = polyline(z=0mm, xy: ($std_w1/2, 2*$std_l+$pad_l+$pad_l1+l) ($pad_w/2, 2*$std_l+$pad_l+2*$pad_l1+l) (-$pad_w/2, 2*$std_l+$pad_l+2*$pad_l1+l) (-$std_w1/2, 2*$std_l+$pad_l+$pad_l1+l) ($std_w1/2, 2*$std_l+$pad_l+$pad_l1+l), closed, covered)
  Polyline5.thicken(-$brd_t)
  Polyline6_SweepFaceAlongNormal1 = sweep_along_normal(Polyline6.face(#528), length=$brd_t)
  Polyline6.delete()
  gnd_1.unite(Polyline1_SweepFaceAlongNormal1, gnd_3, Polyline3_SweepFaceAlongNormal1, gnd_5)
  gnd_2.unite(gnd_4, gnd_6, Polyline2_SweepFaceAlongNormal1, Polyline4_SweepFaceAlongNormal1)
  sig.unite(pad, pad1, Polyline5, Polyline6_SweepFaceAlongNormal1)
boundaries and excitations:
  Rad1: Radiation Objects=ab
  1: Wave Port Objects=port1 NumModes=3 Modes{Mode1{CharImp=Zpi} Mode2{CharImp=Zpi} Mode3{CharImp=Zpi}}
  2: Wave Port Objects=port2 NumModes=3 Modes{Mode1{CharImp=Zpi} Mode2{CharImp=Zpi} Mode3{CharImp=Zpi}}
setups:
  Setup1: HfssDriven Frequency=5GHz MaxDeltaS=0.02 MaximumPasses=15 MinimumPasses=1 MinimumConvergedPasses=1 PercentRefinement=30 BasisOrder=1 PortAccuracy=2 RayDensityPerWavelength=4 MaxNumberOfBounces=5
    sweep Sweep: 1GHz to 10GHz, 91 points; Type=Interpolating InterpTolerance=0.5 InterpMaxSolns=250 InterpUsePortImped=false PassivityErrorTolerance=0.0001
  Setup2: HfssDriven Frequency=50GHz MaxDeltaS=0.02 MaximumPasses=15 MinimumPasses=1 MinimumConvergedPasses=1 PercentRefinement=30 BasisOrder=1 PortAccuracy=2 RayDensityPerWavelength=4 MaxNumberOfBounces=5
    sweep Sweep: 45GHz to 55GHz, 51 points; Type=Interpolating InterpTolerance=0.5 InterpMaxSolns=250 InterpUsePortImped=false PassivityErrorTolerance=0.0001
  Setup3: HfssDriven Frequency=90GHz MaxDeltaS=0.02 MaximumPasses=15 MinimumPasses=1 MinimumConvergedPasses=1 PercentRefinement=30 BasisOrder=1 PortAccuracy=2 RayDensityPerWavelength=4 MaxNumberOfBounces=5
    sweep Sweep: 85GHz to 95GHz, 51 points; Type=Interpolating InterpTolerance=0.5 InterpMaxSolns=250 InterpUsePortImped=false PassivityErrorTolerance=0.0001
source amplitudes:
  1:1: 1W 0deg
  1:2, 1:3, 2:1, 2:2, 2:3: 0W 0deg
optimetrics:
  OptimizationSetup1: Optimization Optimizer="Quasi Newton" AnalysisStopOptions{StopForNumIteration MaxNumIteration=1000 MinNumIteration=10} CostFuncNormType=L2 Acceptable_Cost=0 Noise=0.0001 UpdateDesignWhenDone
    vary $std_g: Min=0.15mm Max=0.5mm MinStep=0.05mm MaxStep=0.2mm MinFocus=0.25mm MaxFocus=0.75mm start=0.168mm
    goal re(Zo(1:1)) == 100 weight 1 on Setup1 : LastAdaptive at Freq 50GHz
  ParametricSetup1: Parametric Sim._Setups=[Setup1]
    sweep $std_g: LIN 0.15mm 0.2mm 0.01mm
field plots:
  Mesh1: MeshPlots over port1.face on Setup1 : LastAdaptive at Freq=5GHz Phase=0deg
  Mag_E1: E Field over port1.face on Setup1 : LastAdaptive at Freq=5GHz Phase=0deg
reports:
  S Parameter Plot 1: dB(S(1:1,1:1)) vs Freq on Setup1 : Sweep [$pad_g=10um $std_g=all]; dB(S(1:1,1:1)) vs Freq on Setup2 : Sweep [$pad_g=10um $std_g=all]; dB(S(1:1,1:1)) vs Freq on Setup3 : Sweep [$pad_g=10um $std_g=all]
  Epsilon Plot 1: Epsilon(1:1) vs Freq on Setup1 : Sweep [$pad_g=10um $std_g=all]; Epsilon(1:1) vs Freq on Setup2 : Sweep [$pad_g=10um $std_g=all]; Epsilon(1:1) vs Freq on Setup3 : Sweep [$pad_g=10um $std_g=all]; markers m1 at 5GHz, m2 at 50GHz, m3 at 90GHz
  Lambda Plot 1: Lambda(1:1) vs Freq on Setup1 : Sweep [$pad_g=10um $std_g=all]; Lambda(1:1) vs Freq on Setup2 : Sweep [$pad_g=10um $std_g=all]; Lambda(1:1) vs Freq on Setup3 : Sweep [$pad_g=10um $std_g=all]; markers m1 at 5GHz, m2 at 50GHz, m3 at 90GHz

design THRU (HFSS, DrivenModal, model units mm)
variables:
  ab_w = 1.5*$brd_w
  ab_h = $port_h+4*$brd_h
  ab_dep = $port_dep+2*$brd_h
geometry:
  pad = box(corner=(-$pad_w/2, 0mm, 0mm), size=($pad_w, $pad_l, $brd_t))
  gnd_1 [copper] = box(corner=(-$pad_w/2-$pad_g, 0mm, 0mm), size=(-$std_w2, $pad_l, $brd_t))
  gnd_2 [copper] = box(corner=($pad_w/2+$pad_g, 0mm, 0mm), size=($std_w2, $pad_l, $brd_t))
  gnd_3 = box(corner=(-$std_w1/2-$std_g, $pad_l+$pad_l1, 0mm), size=(-$std_w2, 2*$std_l, $brd_t))
  gnd_4 = box(corner=($std_w1/2+$std_g, $pad_l+$pad_l1, 0mm), size=($std_w2, 2*$std_l, $brd_t))
  sig [copper] = box(corner=(-$std_w1/2, $pad_l+$pad_l1, 0mm), size=($std_w1, 2*$std_l, $brd_t))
  gnd_5 = box(corner=(-$pad_w/2-$pad_g, 2*($std_l+$pad_l+$pad_l1), 0mm), size=(-$std_w2, -$pad_l, $brd_t))
  gnd_6 = box(corner=($pad_w/2+$pad_g, 2*($std_l+$pad_l+$pad_l1), 0mm), size=($std_w2, -$pad_l, $brd_t))
  pad1 = box(corner=(-$pad_w/2, 2*($std_l+$pad_l+$pad_l1), 0mm), size=($pad_w, -$pad_l, $brd_t))
  Polyline1 = polyline(z=0mm, xy: (-$pad_w/2-$pad_g, $pad_l) (-$std_w1/2-$std_g, $pad_l+$pad_l1) (-$std_w1/2-$std_g-$std_w2, $pad_l+$pad_l1) (-$pad_w/2-$pad_g-$std_w2, $pad_l) (-$pad_w/2-$pad_g, $pad_l), closed, covered)
  Polyline2 = polyline(z=0mm, xy: ($pad_w/2+$pad_g, $pad_l) ($std_w1/2+$std_g, $pad_l+$pad_l1) ($std_w1/2+$std_g+$std_w2, $pad_l+$pad_l1) ($pad_w/2+$pad_g+$std_w2, $pad_l) ($pad_w/2+$pad_g, $pad_l), closed, covered)
  Polyline3 = polyline(z=0mm, xy: (-$std_w1/2-$std_g, $pad_l+2*($std_l)+$pad_l1) (-$pad_w/2-$pad_g, 2*($pad_l1+$std_l)+$pad_l) (-$pad_w/2-$pad_g-$std_w2, 2*($pad_l1+$std_l)+$pad_l) (-$std_w1/2-$std_g-$std_w2, $pad_l+2*($std_l)+$pad_l1) (-$std_w1/2-$std_g, $pad_l+2*($std_l)+$pad_l1), closed, covered)
  Polyline4 = polyline(z=0mm, xy: ($std_w1/2+$std_g, $pad_l+2*($std_l)+$pad_l1) ($pad_w/2+$pad_g, 2*($pad_l1+$std_l)+$pad_l) ($pad_w/2+$pad_g+$std_w2, 2*($pad_l1+$std_l)+$pad_l) ($std_w1/2+$std_g+$std_w2, $pad_l+2*($std_l)+$pad_l1) ($std_w1/2+$std_g, $pad_l+2*($std_l)+$pad_l1), closed, covered)
  Polyline1_SweepFaceAlongNormal1 = sweep_along_normal(Polyline1.face(#350), length=$brd_t)
  Polyline1.delete()
  Polyline2_SweepFaceAlongNormal1 = sweep_along_normal(Polyline2.face(#362), length=-$brd_t)
  Polyline2.delete()
  Polyline3_SweepFaceAlongNormal1 = sweep_along_normal(Polyline3.face(#374), length=$brd_t)
  Polyline3.delete()
  Polyline4_SweepFaceAlongNormal1 = sweep_along_normal(Polyline4.face(#386), length=-$brd_t)
  Polyline4.delete()
  Polyline5 = polyline(z=0mm, xy: (-$pad_w/2, $pad_l) (-$std_w1/2, $pad_l+$pad_l1) ($std_w1/2, $pad_l+$pad_l1) ($pad_w/2, $pad_l) (-$pad_w/2, $pad_l), closed, covered)
  Polyline6 = polyline(z=0mm, xy: ($std_w1/2, 2*$std_l+$pad_l+$pad_l1) ($pad_w/2, 2*$std_l+$pad_l+2*$pad_l1) (-$pad_w/2, 2*$std_l+$pad_l+2*$pad_l1) (-$std_w1/2, 2*$std_l+$pad_l+$pad_l1) ($std_w1/2, 2*$std_l+$pad_l+$pad_l1), closed, covered)
  Polyline5.thicken(-$brd_t)
  Polyline6_SweepFaceAlongNormal1 = sweep_along_normal(Polyline6.face(#528), length=$brd_t)
  Polyline6.delete()
  gnd_1.unite(Polyline1_SweepFaceAlongNormal1, gnd_3, Polyline3_SweepFaceAlongNormal1, gnd_5)
  gnd_2.unite(gnd_4, gnd_6, Polyline2_SweepFaceAlongNormal1, Polyline4_SweepFaceAlongNormal1)
  sig.unite(pad, pad1, Polyline5, Polyline6_SweepFaceAlongNormal1)
setups:
  Setup1: HfssDriven Frequency=90GHz MaxDeltaE=0.1 MaximumPasses=15 MinimumPasses=1 MinimumConvergedPasses=1 PercentRefinement=30 BasisOrder=1 RayDensityPerWavelength=4 MaxNumberOfBounces=5
    sweep Sweep: 85GHz to 95GHz, 51 points; Type=Interpolating InterpTolerance=0.5 InterpMaxSolns=250 InterpUsePortImped=false PassivityErrorTolerance=0.0001
optimetrics:
  OptimizationSetup1: Optimization Optimizer="Quasi Newton" AnalysisStopOptions{StopForNumIteration MaxNumIteration=1000 MinNumIteration=10} CostFuncNormType=L2 Acceptable_Cost=0 Noise=0.0001 UpdateDesignWhenDone
    vary $std_g: Min=0.15mm Max=0.5mm MinStep=0.05mm MaxStep=0.2mm MinFocus=0.25mm MaxFocus=0.75mm start=0.168mm
    goal re(Zo(1:1)) == 100 weight 1 on Setup1 : LastAdaptive at Freq 50GHz
  ParametricSetup1: Parametric Sim._Setups=[Setup1]
    sweep $std_g: LIN 0.15mm 0.2mm 0.01mm
reports:
  Port Zo Plot 1: re(Zo(1:1)) vs $std_g on Setup1 : LastAdaptive [Freq=all]
  S Parameter Plot 1: dB(S(1:1,1:1)) vs Freq on Setup1 : Sweep [$std_g=all]
  Lambda Plot 1: Lambda(1:1) vs Freq on Setup1 : Sweep [$pad_g=27um $std_g=all]; markers m1 at 90GHz
  Epsilon Plot 1: Epsilon(1:1) vs Freq on Setup1 : Sweep [$pad_g=27um $std_g=all]; markers m1 at 90GHz

design LINE (HFSS, DrivenModal, model units mm)
variables:
  ab_w = 1.5*$brd_w
  ab_h = $port_h+4*$brd_h
  ab_dep = $port_dep+2*$brd_h
  l = 5mm
geometry:
  pad = box(corner=(-$pad_w/2, 0mm, 0mm), size=($pad_w, $pad_l, $brd_t))
  gnd_1 [copper] = box(corner=(-$pad_w/2-$pad_g, 0mm, 0mm), size=(-$std_w2, $pad_l, $brd_t))
  gnd_2 [copper] = box(corner=($pad_w/2+$pad_g, 0mm, 0mm), size=($std_w2, $pad_l, $brd_t))
  gnd_3 = box(corner=(-$std_w1/2-$std_g, $pad_l+$pad_l1, 0mm), size=(-$std_w2, 2*$std_l+l, $brd_t))
  gnd_4 = box(corner=($std_w1/2+$std_g, $pad_l+$pad_l1, 0mm), size=($std_w2, 2*$std_l+l, $brd_t))
  sig [copper] = box(corner=(-$std_w1/2, $pad_l+$pad_l1, 0mm), size=($std_w1, 2*$std_l+l, $brd_t))
  gnd_5 = box(corner=(-$pad_w/2-$pad_g, 2*($std_l+$pad_l+$pad_l1)+l, 0mm), size=(-$std_w2, -$pad_l, $brd_t))
  gnd_6 = box(corner=($pad_w/2+$pad_g, 2*($std_l+$pad_l+$pad_l1)+l, 0mm), size=($std_w2, -$pad_l, $brd_t))
  pad1 = box(corner=(-$pad_w/2, 2*($std_l+$pad_l+$pad_l1)+l, 0mm), size=($pad_w, -$pad_l, $brd_t))
  Polyline1 = polyline(z=0mm, xy: (-$pad_w/2-$pad_g, $pad_l) (-$std_w1/2-$std_g, $pad_l+$pad_l1) (-$std_w1/2-$std_g-$std_w2, $pad_l+$pad_l1) (-$pad_w/2-$pad_g-$std_w2, $pad_l) (-$pad_w/2-$pad_g, $pad_l), closed, covered)
  Polyline2 = polyline(z=0mm, xy: ($pad_w/2+$pad_g, $pad_l) ($std_w1/2+$std_g, $pad_l+$pad_l1) ($std_w1/2+$std_g+$std_w2, $pad_l+$pad_l1) ($pad_w/2+$pad_g+$std_w2, $pad_l) ($pad_w/2+$pad_g, $pad_l), closed, covered)
  Polyline3 = polyline(z=0mm, xy: (-$std_w1/2-$std_g, $pad_l+2*($std_l)+$pad_l1+l) (-$pad_w/2-$pad_g, 2*($pad_l1+$std_l)+$pad_l+l) (-$pad_w/2-$pad_g-$std_w2, 2*($pad_l1+$std_l)+$pad_l+l) (-$std_w1/2-$std_g-$std_w2, $pad_l+2*($std_l)+$pad_l1+l) (-$std_w1/2-$std_g, $pad_l+2*($std_l)+$pad_l1+l), closed, covered)
  Polyline4 = polyline(z=0mm, xy: ($std_w1/2+$std_g, $pad_l+2*($std_l)+$pad_l1+l) ($pad_w/2+$pad_g, 2*($pad_l1+$std_l)+$pad_l+l) ($pad_w/2+$pad_g+$std_w2, 2*($pad_l1+$std_l)+$pad_l+l) ($std_w1/2+$std_g+$std_w2, $pad_l+2*($std_l)+$pad_l1+l) ($std_w1/2+$std_g, $pad_l+2*($std_l)+$pad_l1+l), closed, covered)
  Polyline1_SweepFaceAlongNormal1 = sweep_along_normal(Polyline1.face(#350), length=$brd_t)
  Polyline1.delete()
  Polyline2_SweepFaceAlongNormal1 = sweep_along_normal(Polyline2.face(#362), length=-$brd_t)
  Polyline2.delete()
  Polyline3_SweepFaceAlongNormal1 = sweep_along_normal(Polyline3.face(#374), length=$brd_t)
  Polyline3.delete()
  Polyline4_SweepFaceAlongNormal1 = sweep_along_normal(Polyline4.face(#386), length=-$brd_t)
  Polyline4.delete()
  Polyline5 = polyline(z=0mm, xy: (-$pad_w/2, $pad_l) (-$std_w1/2, $pad_l+$pad_l1) ($std_w1/2, $pad_l+$pad_l1) ($pad_w/2, $pad_l) (-$pad_w/2, $pad_l), closed, covered)
  Polyline6 = polyline(z=0mm, xy: ($std_w1/2, 2*$std_l+$pad_l+$pad_l1+l) ($pad_w/2, 2*$std_l+$pad_l+2*$pad_l1+l) (-$pad_w/2, 2*$std_l+$pad_l+2*$pad_l1+l) (-$std_w1/2, 2*$std_l+$pad_l+$pad_l1+l) ($std_w1/2, 2*$std_l+$pad_l+$pad_l1+l), closed, covered)
  Polyline5.thicken(-$brd_t)
  Polyline6_SweepFaceAlongNormal1 = sweep_along_normal(Polyline6.face(#528), length=$brd_t)
  Polyline6.delete()
  gnd_1.unite(Polyline1_SweepFaceAlongNormal1, gnd_3, Polyline3_SweepFaceAlongNormal1, gnd_5)
  gnd_2.unite(gnd_4, gnd_6, Polyline2_SweepFaceAlongNormal1, Polyline4_SweepFaceAlongNormal1)
  sig.unite(pad, pad1, Polyline5, Polyline6_SweepFaceAlongNormal1)
setups:
  Setup1: HfssDriven Frequency=5GHz MaxDeltaE=0.1 MaximumPasses=15 MinimumPasses=1 MinimumConvergedPasses=1 PercentRefinement=30 BasisOrder=1 RayDensityPerWavelength=4 MaxNumberOfBounces=5
    sweep Sweep: 1GHz to 10GHz, 91 points; Type=Interpolating InterpTolerance=0.5 InterpMaxSolns=250 InterpUsePortImped=false PassivityErrorTolerance=0.0001
  Setup2: HfssDriven Frequency=50GHz MaxDeltaE=0.1 MaximumPasses=15 MinimumPasses=1 MinimumConvergedPasses=1 PercentRefinement=30 BasisOrder=1 RayDensityPerWavelength=4 MaxNumberOfBounces=5
    sweep Sweep: 45GHz to 55GHz, 51 points; Type=Interpolating InterpTolerance=0.5 InterpMaxSolns=250 InterpUsePortImped=false PassivityErrorTolerance=0.0001
  Setup3: HfssDriven Frequency=90GHz MaxDeltaE=0.1 MaximumPasses=15 MinimumPasses=1 MinimumConvergedPasses=1 PercentRefinement=30 BasisOrder=1 RayDensityPerWavelength=4 MaxNumberOfBounces=5
    sweep Sweep: 85GHz to 95GHz, 51 points; Type=Interpolating InterpTolerance=0.5 InterpMaxSolns=250 InterpUsePortImped=false PassivityErrorTolerance=0.0001
optimetrics:
  OptimizationSetup1: Optimization Optimizer="Quasi Newton" AnalysisStopOptions{StopForNumIteration MaxNumIteration=1000 MinNumIteration=10} CostFuncNormType=L2 Acceptable_Cost=0 Noise=0.0001 UpdateDesignWhenDone
    vary $std_g: Min=0.15mm Max=0.5mm MinStep=0.05mm MaxStep=0.2mm MinFocus=0.25mm MaxFocus=0.75mm start=0.168mm
    goal re(Zo(1:1)) == 100 weight 1 on Setup1 : LastAdaptive at Freq 50GHz
  ParametricSetup1: Parametric Sim._Setups=[Setup1]
    sweep $std_g: LIN 0.15mm 0.2mm 0.01mm
reports:
  Port Zo Plot 1: re(Zo(1:1)) vs $std_g on Setup1 : LastAdaptive [Freq=all]
  S Parameter Plot 1: dB(S(1:1,1:1)), dB(S(2:1,1:1)) vs Freq on Setup1 : Sweep [$std_g=all]; dB(S(1:1,1:1)), dB(S(2:1,1:1)) vs Freq on Setup2 : Sweep [$std_g=all]; dB(S(1:1,1:1)), dB(S(2:1,1:1)) vs Freq on Setup3 : Sweep [$std_g=all]
  Lambda Plot 1: Lambda(1:1) vs Freq on Setup1 : Sweep [$pad_g=27um $std_g=all]; markers m1 at 90GHz
  Epsilon Plot 1: Epsilon(1:1) vs Freq on Setup1 : Sweep [$pad_g=27um $std_g=all]; markers m1 at 90GHz

design REFL (HFSS, DrivenModal, model units mm)
variables:
  ab_w = 1.5*$brd_w
  ab_h = $port_h+4*$brd_h
  ab_dep = $port_dep+2*$brd_h
  l = $std_l1
geometry:
  pad = box(corner=(-$pad_w/2, 0mm, 0mm), size=($pad_w, $pad_l, $brd_t))
  gnd_1 = box(corner=(-$pad_w/2-$pad_g, 0mm, 0mm), size=(-$std_w2, $pad_l, $brd_t))
  gnd_2 = box(corner=($pad_w/2+$pad_g, 0mm, 0mm), size=($std_w2, $pad_l, $brd_t))
  gnd_3 = box(corner=(-$std_w1/2-$std_g, $pad_l+$pad_l1, 0mm), size=(-$std_w2, 2*$std_l+l, $brd_t))
  gnd_4 = box(corner=($std_w1/2+$std_g, $pad_l+$pad_l1, 0mm), size=($std_w2, 2*$std_l+l, $brd_t))
  sig [copper] = box(corner=(-$std_w1/2, $pad_l+$pad_l1, 0mm), size=($std_w1, 2*$std_l+l, $brd_t))
  gnd_5 = box(corner=(-$pad_w/2-$pad_g, 2*($std_l+$pad_l+$pad_l1)+l, 0mm), size=(-$std_w2, -$pad_l, $brd_t))
  gnd_6 = box(corner=($pad_w/2+$pad_g, 2*($std_l+$pad_l+$pad_l1)+l, 0mm), size=($std_w2, -$pad_l, $brd_t))
  pad1 = box(corner=(-$pad_w/2, 2*($std_l+$pad_l+$pad_l1)+l, 0mm), size=($pad_w, -$pad_l, $brd_t))
  Polyline1 = polyline(z=0mm, xy: (-$pad_w/2-$pad_g, $pad_l) (-$std_w1/2-$std_g, $pad_l+$pad_l1) (-$std_w1/2-$std_g-$std_w2, $pad_l+$pad_l1) (-$pad_w/2-$pad_g-$std_w2, $pad_l) (-$pad_w/2-$pad_g, $pad_l), closed, covered)
  Polyline2 = polyline(z=0mm, xy: ($pad_w/2+$pad_g, $pad_l) ($std_w1/2+$std_g, $pad_l+$pad_l1) ($std_w1/2+$std_g+$std_w2, $pad_l+$pad_l1) ($pad_w/2+$pad_g+$std_w2, $pad_l) ($pad_w/2+$pad_g, $pad_l), closed, covered)
  Polyline3 = polyline(z=0mm, xy: (-$std_w1/2-$std_g, $pad_l+2*($std_l)+$pad_l1+l) (-$pad_w/2-$pad_g, 2*($pad_l1+$std_l)+$pad_l+l) (-$pad_w/2-$pad_g-$std_w2, 2*($pad_l1+$std_l)+$pad_l+l) (-$std_w1/2-$std_g-$std_w2, $pad_l+2*($std_l)+$pad_l1+l) (-$std_w1/2-$std_g, $pad_l+2*($std_l)+$pad_l1+l), closed, covered)
  Polyline4 = polyline(z=0mm, xy: ($std_w1/2+$std_g, $pad_l+2*($std_l)+$pad_l1+l) ($pad_w/2+$pad_g, 2*($pad_l1+$std_l)+$pad_l+l) ($pad_w/2+$pad_g+$std_w2, 2*($pad_l1+$std_l)+$pad_l+l) ($std_w1/2+$std_g+$std_w2, $pad_l+2*($std_l)+$pad_l1+l) ($std_w1/2+$std_g, $pad_l+2*($std_l)+$pad_l1+l), closed, covered)
  Polyline1_SweepFaceAlongNormal1 = sweep_along_normal(Polyline1.face(#350), length=$brd_t)
  Polyline1.delete()
  Polyline2_SweepFaceAlongNormal1 = sweep_along_normal(Polyline2.face(#362), length=-$brd_t)
  Polyline2.delete()
  Polyline3_SweepFaceAlongNormal1 = sweep_along_normal(Polyline3.face(#374), length=$brd_t)
  Polyline3.delete()
  Polyline4_SweepFaceAlongNormal1 = sweep_along_normal(Polyline4.face(#386), length=-$brd_t)
  Polyline4.delete()
  Polyline5 = polyline(z=0mm, xy: (-$pad_w/2, $pad_l) (-$std_w1/2, $pad_l+$pad_l1) ($std_w1/2, $pad_l+$pad_l1) ($pad_w/2, $pad_l) (-$pad_w/2, $pad_l), closed, covered)
  Polyline6 = polyline(z=0mm, xy: ($std_w1/2, 2*$std_l+$pad_l+$pad_l1+l) ($pad_w/2, 2*$std_l+$pad_l+2*$pad_l1+l) (-$pad_w/2, 2*$std_l+$pad_l+2*$pad_l1+l) (-$std_w1/2, 2*$std_l+$pad_l+$pad_l1+l) ($std_w1/2, 2*$std_l+$pad_l+$pad_l1+l), closed, covered)
  Polyline5.thicken(-$brd_t)
  Polyline6_SweepFaceAlongNormal1 = sweep_along_normal(Polyline6.face(#528), length=$brd_t)
  Polyline6.delete()
  gnd_1.unite(Polyline1_SweepFaceAlongNormal1, gnd_3, Polyline3_SweepFaceAlongNormal1, gnd_5)
  gnd_2.unite(gnd_4, gnd_6, Polyline2_SweepFaceAlongNormal1, Polyline4_SweepFaceAlongNormal1)
  sig.unite(pad, pad1, Polyline5, Polyline6_SweepFaceAlongNormal1)
  sig1 = box(corner=(-$std_w1/2, $pad_l+$pad_l1+$std_l, 0mm), size=(-$std_g, l, $brd_t))
  sig2 = box(corner=($std_w1/2, $pad_l+$pad_l1+$std_l, 0mm), size=($std_g, l, $brd_t))
  sig.unite(sig1, sig2, gnd_1, gnd_2)
setups:
  Setup1: HfssDriven Frequency=5GHz MaxDeltaE=0.1 MaximumPasses=15 MinimumPasses=1 MinimumConvergedPasses=1 PercentRefinement=30 BasisOrder=1 RayDensityPerWavelength=4 MaxNumberOfBounces=5
    sweep Sweep: 1GHz to 10GHz, 91 points; Type=Interpolating InterpTolerance=0.5 InterpMaxSolns=250 InterpUsePortImped=false PassivityErrorTolerance=0.0001
  Setup2: HfssDriven Frequency=50GHz MaxDeltaE=0.1 MaximumPasses=15 MinimumPasses=1 MinimumConvergedPasses=1 PercentRefinement=30 BasisOrder=1 RayDensityPerWavelength=4 MaxNumberOfBounces=5
    sweep Sweep: 45GHz to 55GHz, 51 points; Type=Interpolating InterpTolerance=0.5 InterpMaxSolns=250 InterpUsePortImped=false PassivityErrorTolerance=0.0001
  Setup3: HfssDriven Frequency=90GHz MaxDeltaE=0.1 MaximumPasses=15 MinimumPasses=1 MinimumConvergedPasses=1 PercentRefinement=30 BasisOrder=1 RayDensityPerWavelength=4 MaxNumberOfBounces=5
    sweep Sweep: 85GHz to 95GHz, 51 points; Type=Interpolating InterpTolerance=0.5 InterpMaxSolns=250 InterpUsePortImped=false PassivityErrorTolerance=0.0001
optimetrics:
  OptimizationSetup1: Optimization Optimizer="Quasi Newton" AnalysisStopOptions{StopForNumIteration MaxNumIteration=1000 MinNumIteration=10} CostFuncNormType=L2 Acceptable_Cost=0 Noise=0.0001 UpdateDesignWhenDone
    vary $std_g: Min=0.15mm Max=0.5mm MinStep=0.05mm MaxStep=0.2mm MinFocus=0.25mm MaxFocus=0.75mm start=0.168mm
    goal re(Zo(1:1)) == 100 weight 1 on Setup1 : LastAdaptive at Freq 50GHz
  ParametricSetup1: Parametric Sim._Setups=[Setup1]
    sweep $std_g: LIN 0.15mm 0.2mm 0.01mm
reports:
  Port Zo Plot 1: re(Zo(1:1)) vs $std_g on Setup1 : LastAdaptive [Freq=all]
  S Parameter Plot 1: dB(S(1:1,1:1)), dB(S(2:1,1:1)) vs Freq on Setup1 : Sweep [$std_g=all]; dB(S(1:1,1:1)), dB(S(2:1,1:1)) vs Freq on Setup2 : Sweep [$std_g=all]; dB(S(1:1,1:1)), dB(S(2:1,1:1)) vs Freq on Setup3 : Sweep [$std_g=all]
  Lambda Plot 1: Lambda(1:1) vs Freq on Setup1 : Sweep [$pad_g=27um $std_g=all]; markers m1 at 90GHz
  Epsilon Plot 1: Epsilon(1:1) vs Freq on Setup1 : Sweep [$pad_g=27um $std_g=all]; markers m1 at 90GHz

design DUT (HFSS, DrivenModal, model units mm)
variables:
  ab_w = 1.5*$brd_w
  ab_h = $port_h+4*$brd_h
  ab_dep = $port_dep+2*$brd_h
  l = $std_l1
geometry:
  pad = box(corner=(-$pad_w/2, 0mm, 0mm), size=($pad_w, $pad_l, $brd_t))
  gnd_1 [copper] = box(corner=(-$pad_w/2-$pad_g, 0mm, 0mm), size=(-$std_w2, $pad_l, $brd_t))
  gnd_2 [copper] = box(corner=($pad_w/2+$pad_g, 0mm, 0mm), size=($std_w2, $pad_l, $brd_t))
  gnd_3 = box(corner=(-$std_w1/2-$std_g, $pad_l+$pad_l1, 0mm), size=(-$std_w2, 2*$std_l+l, $brd_t))
  gnd_4 = box(corner=($std_w1/2+$std_g, $pad_l+$pad_l1, 0mm), size=($std_w2, 2*$std_l+l, $brd_t))
  sig [copper] = box(corner=(-$std_w1/2, $pad_l+$pad_l1, 0mm), size=($std_w1, 2*$std_l+l, $brd_t))
  gnd_5 = box(corner=(-$pad_w/2-$pad_g, 2*($std_l+$pad_l+$pad_l1)+l, 0mm), size=(-$std_w2, -$pad_l, $brd_t))
  gnd_6 = box(corner=($pad_w/2+$pad_g, 2*($std_l+$pad_l+$pad_l1)+l, 0mm), size=($std_w2, -$pad_l, $brd_t))
  pad1 = box(corner=(-$pad_w/2, 2*($std_l+$pad_l+$pad_l1)+l, 0mm), size=($pad_w, -$pad_l, $brd_t))
  Polyline1 = polyline(z=0mm, xy: (-$pad_w/2-$pad_g, $pad_l) (-$std_w1/2-$std_g, $pad_l+$pad_l1) (-$std_w1/2-$std_g-$std_w2, $pad_l+$pad_l1) (-$pad_w/2-$pad_g-$std_w2, $pad_l) (-$pad_w/2-$pad_g, $pad_l), closed, covered)
  Polyline2 = polyline(z=0mm, xy: ($pad_w/2+$pad_g, $pad_l) ($std_w1/2+$std_g, $pad_l+$pad_l1) ($std_w1/2+$std_g+$std_w2, $pad_l+$pad_l1) ($pad_w/2+$pad_g+$std_w2, $pad_l) ($pad_w/2+$pad_g, $pad_l), closed, covered)
  Polyline3 = polyline(z=0mm, xy: (-$std_w1/2-$std_g, $pad_l+2*($std_l)+$pad_l1+l) (-$pad_w/2-$pad_g, 2*($pad_l1+$std_l)+$pad_l+l) (-$pad_w/2-$pad_g-$std_w2, 2*($pad_l1+$std_l)+$pad_l+l) (-$std_w1/2-$std_g-$std_w2, $pad_l+2*($std_l)+$pad_l1+l) (-$std_w1/2-$std_g, $pad_l+2*($std_l)+$pad_l1+l), closed, covered)
  Polyline4 = polyline(z=0mm, xy: ($std_w1/2+$std_g, $pad_l+2*($std_l)+$pad_l1+l) ($pad_w/2+$pad_g, 2*($pad_l1+$std_l)+$pad_l+l) ($pad_w/2+$pad_g+$std_w2, 2*($pad_l1+$std_l)+$pad_l+l) ($std_w1/2+$std_g+$std_w2, $pad_l+2*($std_l)+$pad_l1+l) ($std_w1/2+$std_g, $pad_l+2*($std_l)+$pad_l1+l), closed, covered)
  Polyline1_SweepFaceAlongNormal1 = sweep_along_normal(Polyline1.face(#350), length=$brd_t)
  Polyline1.delete()
  Polyline2_SweepFaceAlongNormal1 = sweep_along_normal(Polyline2.face(#362), length=-$brd_t)
  Polyline2.delete()
  Polyline3_SweepFaceAlongNormal1 = sweep_along_normal(Polyline3.face(#374), length=$brd_t)
  Polyline3.delete()
  Polyline4_SweepFaceAlongNormal1 = sweep_along_normal(Polyline4.face(#386), length=-$brd_t)
  Polyline4.delete()
  Polyline5 = polyline(z=0mm, xy: (-$pad_w/2, $pad_l) (-$std_w1/2, $pad_l+$pad_l1) ($std_w1/2, $pad_l+$pad_l1) ($pad_w/2, $pad_l) (-$pad_w/2, $pad_l), closed, covered)
  Polyline6 = polyline(z=0mm, xy: ($std_w1/2, 2*$std_l+$pad_l+$pad_l1+l) ($pad_w/2, 2*$std_l+$pad_l+2*$pad_l1+l) (-$pad_w/2, 2*$std_l+$pad_l+2*$pad_l1+l) (-$std_w1/2, 2*$std_l+$pad_l+$pad_l1+l) ($std_w1/2, 2*$std_l+$pad_l+$pad_l1+l), closed, covered)
  Polyline5.thicken(-$brd_t)
  Polyline6_SweepFaceAlongNormal1 = sweep_along_normal(Polyline6.face(#528), length=$brd_t)
  Polyline6.delete()
  gnd_1.unite(Polyline1_SweepFaceAlongNormal1, gnd_3, Polyline3_SweepFaceAlongNormal1, gnd_5)
  gnd_2.unite(gnd_4, gnd_6, Polyline2_SweepFaceAlongNormal1, Polyline4_SweepFaceAlongNormal1)
  sig.unite(pad, pad1, Polyline5, Polyline6_SweepFaceAlongNormal1)
  sig1 = box(corner=(-$std_w1/2, $pad_l+$pad_l1+$std_l, 0mm), size=($std_w1, l, $brd_t))
  sig.subtract(sig1)
setups:
  Setup1: HfssDriven Frequency=5GHz MaxDeltaE=0.1 MaximumPasses=15 MinimumPasses=1 MinimumConvergedPasses=1 PercentRefinement=30 BasisOrder=1 RayDensityPerWavelength=4 MaxNumberOfBounces=5
    sweep Sweep: 1GHz to 10GHz, 91 points; Type=Interpolating InterpTolerance=0.5 InterpMaxSolns=250 InterpUsePortImped=false PassivityErrorTolerance=0.0001
  Setup2: HfssDriven Frequency=50GHz MaxDeltaE=0.1 MaximumPasses=15 MinimumPasses=1 MinimumConvergedPasses=1 PercentRefinement=30 BasisOrder=1 RayDensityPerWavelength=4 MaxNumberOfBounces=5
    sweep Sweep: 45GHz to 55GHz, 51 points; Type=Interpolating InterpTolerance=0.5 InterpMaxSolns=250 InterpUsePortImped=false PassivityErrorTolerance=0.0001
  Setup3: HfssDriven Frequency=90GHz MaxDeltaE=0.1 MaximumPasses=15 MinimumPasses=1 MinimumConvergedPasses=1 PercentRefinement=30 BasisOrder=1 RayDensityPerWavelength=4 MaxNumberOfBounces=5
    sweep Sweep: 85GHz to 95GHz, 51 points; Type=Interpolating InterpTolerance=0.5 InterpMaxSolns=250 InterpUsePortImped=false PassivityErrorTolerance=0.0001
optimetrics:
  OptimizationSetup1: Optimization Optimizer="Quasi Newton" AnalysisStopOptions{StopForNumIteration MaxNumIteration=1000 MinNumIteration=10} CostFuncNormType=L2 Acceptable_Cost=0 Noise=0.0001 UpdateDesignWhenDone
    vary $std_g: Min=0.15mm Max=0.5mm MinStep=0.05mm MaxStep=0.2mm MinFocus=0.25mm MaxFocus=0.75mm start=0.168mm
    goal re(Zo(1:1)) == 100 weight 1 on Setup1 : LastAdaptive at Freq 50GHz
  ParametricSetup1: Parametric Sim._Setups=[Setup1]
    sweep $std_g: LIN 0.15mm 0.2mm 0.01mm
reports:
  Port Zo Plot 1: re(Zo(1:1)) vs $std_g on Setup1 : LastAdaptive [Freq=all]
  S Parameter Plot 1: dB(S(1:1,1:1)), dB(S(2:1,1:1)) vs Freq on Setup1 : Sweep [$std_g=all]; dB(S(1:1,1:1)), dB(S(2:1,1:1)) vs Freq on Setup2 : Sweep [$std_g=all]; dB(S(1:1,1:1)), dB(S(2:1,1:1)) vs Freq on Setup3 : Sweep [$std_g=all]
  Lambda Plot 1: Lambda(1:1) vs Freq on Setup1 : Sweep [$pad_g=27um $std_g=all]; markers m1 at 90GHz
  Epsilon Plot 1: Epsilon(1:1) vs Freq on Setup1 : Sweep [$pad_g=27um $std_g=all]; markers m1 at 90GHz
